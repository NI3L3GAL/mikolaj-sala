.include OPAx134.lib
C1 N002 IN 6.7n
C2 N003 N002 6.7n
XU1 N003 HP1 VCC VEE HP1 OPAx134
R4 HP1 N002 2.4k tol=1
R5 N003 0 2.4k tol=1
R6 N006 IN 23.7k tol=1
XU2 N007 LP1 VCC VEE LP1 OPAx134
R7 N007 N006 23.7k tol=1
C3 N007 0 67n
C4 LP1 N006 67n
VIN1 IN 0 AC
VCC1 VCC 0 SINE(15 0.02 50)
VEE1 VEE 0 SINE(-15 0.02 50)
C5 N014 N013 67n
XU3 N014 N010 VCC VEE N010 OPAx134
R8 N010 N013 23.7k tol=1
R9 N014 0 23.7k tol=1
R10 N011 N010 2.4k tol=1
XU4 N012 MB VCC VEE MB OPAx134
R11 N012 N011 2.4k tol=1
C6 N012 0 6.7n
C7 MB N011 6.7n
C8 N013 IN 67n
XU5 0 N004 VCC VEE OUT OPAx134
R12 OUT N004 10k tol=1
R13 N004 LPG 100 tol=1
R14 N004 MBG 100 tol=1
XU6 0 N008 VCC VEE MB1 OPAx134
R15 N008 MB 1k tol=1
R16 MB1 N008 1k tol=1
R17 HPG N004 100 tol=1
XU7 0 N001 VCC VEE HPG OPAx134
R_HGAIN1 HPG N001 1k tol=1
XU8 0 N005 VCC VEE LPG OPAx134
R_LGAIN1 LPG N005 1k tol=1
XU9 0 N009 VCC VEE MBG OPAx134
R_MGAIN1 MBG N009 1k tol=1
R18 N009 MB1 1k tol=1
R19 N001 HP1 1k tol=1
R20 N005 LP1 1k tol=1
.ac dec 100 10 30k

.end
